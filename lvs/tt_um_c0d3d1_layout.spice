* NGSPICE file created from bg_core_route_all.ext - technology: sky130A

.subckt sky130_fd_pr__rf_pnp_05v5_W3p40L3p40 Emitter Collector Base m=1
X0 Collector Base Emitter sky130_fd_pr__pnp_05v5_W3p40L3p40
**devattr s=462400,2720
.ends

.subckt sky130_fd_pr__res_high_po_5p73_4CGAJ9 B R1 R2
X0 R1 R2 B sky130_fd_pr__res_high_po_5p73 l=5.73
.ends

.subckt sky130_fd_pr__res_xhigh_po_1p41_G8RHRS B R1 R2
X0 R1 R2 B sky130_fd_pr__res_xhigh_po_1p41 l=5.12
.ends

.subckt sky130_fd_pr__res_high_po_1p41_TTZ92X B R1 R2
X0 R1 R2 B sky130_fd_pr__res_high_po_1p41 l=2.45
.ends

.subckt sky130_fd_pr__res_xhigh_po_1p41_9D57HL B R1 R2
X0 R1 R2 B sky130_fd_pr__res_xhigh_po_1p41 l=2.65
.ends

.subckt sky130_fd_pr__pfet_01v8_lvt_EZF7CS B D0 G0 S1 G1 D2 G2 S3 G3 a_231_n3000#
X0 D2 G1 S1 B sky130_fd_pr__pfet_01v8_lvt ad=4.35 pd=30.29 as=4.35 ps=30.29 w=30 l=0.36
X1 a_231_n3000# G3 S3 B sky130_fd_pr__pfet_01v8_lvt ad=8.7 pd=60.58 as=4.35 ps=30.29 w=30 l=0.36
X2 S1 G0 D0 B sky130_fd_pr__pfet_01v8_lvt ad=4.35 pd=30.29 as=8.7 ps=60.58 w=30 l=0.36
X3 S3 G2 D2 B sky130_fd_pr__pfet_01v8_lvt ad=4.35 pd=30.29 as=4.35 ps=30.29 w=30 l=0.36
.ends

.subckt sky130_fd_pr__nfet_01v8_Y2657Z B D S G
X0 S G D B sky130_fd_pr__nfet_01v8 ad=1.74 pd=12.58 as=1.74 ps=12.58 w=6 l=0.36
.ends

.subckt sky130_fd_pr__res_xhigh_po_1p41_YSGX8S B R1 R2
X0 R1 R2 B sky130_fd_pr__res_xhigh_po_1p41 l=16.75
.ends

.subckt sky130_fd_pr__nfet_01v8_W965F3 B D0 G0 S1 G1
X0 S1 G0 D0 B sky130_fd_pr__nfet_01v8 ad=2.61 pd=18.29 as=5.22 ps=36.58 w=18 l=0.36
X1 a_101_n1800# G1 S1 B sky130_fd_pr__nfet_01v8 ad=5.22 pd=36.58 as=2.61 ps=18.29 w=18 l=0.36
.ends

.subckt sky130_fd_pr__pfet_01v8_lvt_ZPPFMQ B D S G
X0 S G D B sky130_fd_pr__pfet_01v8_lvt ad=0.87 pd=6.58 as=0.87 ps=6.58 w=3 l=0.72
.ends

.subckt sky130_fd_pr__pfet_01v8_lvt_D7EHUM B D0 G0 S1 G1 D2 G2 S3 G3 D4 G4 S5 G5 D6
+ G6 S7 G7
X0 D4 G3 S3 B sky130_fd_pr__pfet_01v8_lvt ad=4.35 pd=30.29 as=4.35 ps=30.29 w=30 l=0.72
X1 D6 G5 S5 B sky130_fd_pr__pfet_01v8_lvt ad=4.35 pd=30.29 as=4.35 ps=30.29 w=30 l=0.72
X2 S3 G2 D2 B sky130_fd_pr__pfet_01v8_lvt ad=4.35 pd=30.29 as=4.35 ps=30.29 w=30 l=0.72
X3 S7 G6 D6 B sky130_fd_pr__pfet_01v8_lvt ad=4.35 pd=30.29 as=4.35 ps=30.29 w=30 l=0.72
X4 D2 G1 S1 B sky130_fd_pr__pfet_01v8_lvt ad=4.35 pd=30.29 as=4.35 ps=30.29 w=30 l=0.72
X5 S5 G4 D4 B sky130_fd_pr__pfet_01v8_lvt ad=4.35 pd=30.29 as=4.35 ps=30.29 w=30 l=0.72
X6 a_779_n3000# G7 S7 B sky130_fd_pr__pfet_01v8_lvt ad=8.7 pd=60.58 as=4.35 ps=30.29 w=30 l=0.72
X7 S1 G0 D0 B sky130_fd_pr__pfet_01v8_lvt ad=4.35 pd=30.29 as=8.7 ps=60.58 w=30 l=0.72
.ends

.subckt sky130_fd_pr__pfet_01v8_lvt_Z7GDFQ B D0 G0 S1 G1 D2 G2 S3 G3 D4 G4 S5 G5
X0 D2 G1 S1 B sky130_fd_pr__pfet_01v8_lvt ad=6.525 pd=45.29 as=6.525 ps=45.29 w=45 l=0.72
X1 a_577_n4500# G5 S5 B sky130_fd_pr__pfet_01v8_lvt ad=13.05 pd=90.58 as=6.525 ps=45.29 w=45 l=0.72
X2 S1 G0 D0 B sky130_fd_pr__pfet_01v8_lvt ad=6.525 pd=45.29 as=13.05 ps=90.58 w=45 l=0.72
X3 D4 G3 S3 B sky130_fd_pr__pfet_01v8_lvt ad=6.525 pd=45.29 as=6.525 ps=45.29 w=45 l=0.72
X4 S3 G2 D2 B sky130_fd_pr__pfet_01v8_lvt ad=6.525 pd=45.29 as=6.525 ps=45.29 w=45 l=0.72
X5 S5 G4 D4 B sky130_fd_pr__pfet_01v8_lvt ad=6.525 pd=45.29 as=6.525 ps=45.29 w=45 l=0.72
.ends

.subckt sky130_fd_pr__pfet_01v8_lvt_EH7T5T B D0 G0 S1 G1 D2 G2 S3 G3 a_231_n3600#
X0 S1 G0 D0 B sky130_fd_pr__pfet_01v8_lvt ad=5.22 pd=36.29 as=10.44 ps=72.58 w=36 l=0.36
X1 S3 G2 D2 B sky130_fd_pr__pfet_01v8_lvt ad=5.22 pd=36.29 as=5.22 ps=36.29 w=36 l=0.36
X2 D2 G1 S1 B sky130_fd_pr__pfet_01v8_lvt ad=5.22 pd=36.29 as=5.22 ps=36.29 w=36 l=0.36
X3 a_231_n3600# G3 S3 B sky130_fd_pr__pfet_01v8_lvt ad=10.44 pd=72.58 as=5.22 ps=36.29 w=36 l=0.36
.ends

.subckt sky130_fd_pr__pfet_01v8_hvt_DPBHHE B D S G
X0 S G D B sky130_fd_pr__pfet_01v8_hvt ad=0.522 pd=4.18 as=0.522 ps=4.18 w=1.8 l=0.36
.ends

.subckt sky130_fd_pr__res_xhigh_po_1p41_7QG8KB B R1 R2
X0 R1 R2 B sky130_fd_pr__res_xhigh_po_1p41 l=5.6
.ends

.subckt sky130_fd_pr__cap_mim_m3_1_STSYNP C2 C1
X0 C1 C2 sky130_fd_pr__cap_mim_m3_1 l=15 w=18
.ends

.subckt sky130_fd_pr__cap_mim_m3_1_QP9YHK C2 C1
X0 C1 C2 sky130_fd_pr__cap_mim_m3_1 l=30 w=30
X1 C1 C2 sky130_fd_pr__cap_mim_m3_1 l=30 w=30
.ends

.subckt bg_core_route_all
XQ2_1 Q2_E VSUBS VSUBS sky130_fd_pr__rf_pnp_05v5_W3p40L3p40 m=1
XQ2_2 Q2_E VSUBS VSUBS sky130_fd_pr__rf_pnp_05v5_W3p40L3p40 m=1
XX1_R2 VSUBS M14_D X1_R2/R2 sky130_fd_pr__res_high_po_5p73_4CGAJ9
XQ2_3 Q2_E VSUBS VSUBS sky130_fd_pr__rf_pnp_05v5_W3p40L3p40 m=1
XR1 VSUBS Vref R2/R1 sky130_fd_pr__res_xhigh_po_1p41_G8RHRS
XR2 VSUBS R2/R1 Q2_E sky130_fd_pr__res_high_po_1p41_TTZ92X
XQ1 Q1_E VSUBS VSUBS sky130_fd_pr__rf_pnp_05v5_W3p40L3p40 m=1
XQ2_4 Q2_E VSUBS VSUBS sky130_fd_pr__rf_pnp_05v5_W3p40L3p40 m=1
XR3 VSUBS R3/R1 R4/R1 sky130_fd_pr__res_xhigh_po_1p41_9D57HL
XM13 M13/B Vref M13/G3 M13/S3 M13/G3 Vref M13/G3 M13/S3 M13/G3 Vref sky130_fd_pr__pfet_01v8_lvt_EZF7CS
XQ2_5 Q2_E VSUBS VSUBS sky130_fd_pr__rf_pnp_05v5_W3p40L3p40 m=1
XX1_M10 VSUBS X1_M10/G VSUBS X1_M10/G sky130_fd_pr__nfet_01v8_Y2657Z
XR4 VSUBS R4/R1 R4/R2 sky130_fd_pr__res_xhigh_po_1p41_YSGX8S
XX1_M11 VSUBS M14_D X1_M11/G1 X1_M11/S1 X1_M11/G1 sky130_fd_pr__nfet_01v8_W965F3
XQ2_6 Q2_E VSUBS VSUBS sky130_fd_pr__rf_pnp_05v5_W3p40L3p40 m=1
XQ2_7 Q2_E VSUBS VSUBS sky130_fd_pr__rf_pnp_05v5_W3p40L3p40 m=1
XX1_M12 X1_M12/B X1_M12/G VDD X1_M12/G sky130_fd_pr__pfet_01v8_lvt_ZPPFMQ
XM1 M1/B R8_CONN M1/G3 M1/S3 M1/G3 R8_CONN M1/G3 M1/S3 M1/G3 R8_CONN sky130_fd_pr__pfet_01v8_lvt_EZF7CS
XX1_M13 X1_M13/B X1_M16/B X1_M12/G VDD X1_M12/G X1_M16/B X1_M12/G VDD X1_M12/G X1_M16/B
+ X1_M12/G VDD X1_M12/G X1_M16/B X1_M12/G X1_M13/S7 X1_M12/G sky130_fd_pr__pfet_01v8_lvt_D7EHUM
XX1_M14 X1_M14/B X1_M14/D0 X1_M12/G X1_M14/S1 X1_M12/G X1_M14/D2 X1_M12/G X1_M14/S3
+ X1_M12/G X1_M14/D4 X1_M12/G X1_M14/S5 X1_M12/G sky130_fd_pr__pfet_01v8_lvt_Z7GDFQ
XX1_M15 X1_M16/B X1_M9/D X1_M15/G3 X1_M16/B X1_M15/G3 X1_M9/D X1_M15/G3 X1_M16/B X1_M15/G3
+ X1_M9/D sky130_fd_pr__pfet_01v8_lvt_EH7T5T
XX1_M16 X1_M16/B X1_M10/G X1_M16/G3 X1_M16/B X1_M16/G3 X1_M10/G X1_M16/G3 X1_M16/B
+ X1_M16/G3 X1_M10/G sky130_fd_pr__pfet_01v8_lvt_EH7T5T
XM3 M3/B Q1_E M3/S Q1_E sky130_fd_pr__pfet_01v8_hvt_DPBHHE
XR8 VSUBS R8_CONN Q1_E sky130_fd_pr__res_xhigh_po_1p41_7QG8KB
XX2_R2 VSUBS X2_R2/R1 X2_R2/R2 sky130_fd_pr__res_high_po_5p73_4CGAJ9
XX1_M9 VSUBS X1_M9/D VSUBS X1_M9/G sky130_fd_pr__nfet_01v8_Y2657Z
XX1_C1 X1_C1/C2 X1_C1/C1 sky130_fd_pr__cap_mim_m3_1_STSYNP
XX1_C2 X1_C2/C2 X1_C2/C1 sky130_fd_pr__cap_mim_m3_1_QP9YHK
XX2_M9 VSUBS X2_M9/D GND X2_M9/G sky130_fd_pr__nfet_01v8_Y2657Z
XX2_C1 X2_C1/C2 X2_C1/C1 sky130_fd_pr__cap_mim_m3_1_STSYNP
XX2_C2 X2_C2/C2 X2_C2/C1 sky130_fd_pr__cap_mim_m3_1_QP9YHK
XX2_M10 VSUBS X2_M9/G GND X2_M9/G sky130_fd_pr__nfet_01v8_Y2657Z
XX2_M11 VSUBS X2_R2/R1 X2_M11/G1 X2_M11/S1 X2_M11/G1 sky130_fd_pr__nfet_01v8_W965F3
XX2_M12 X2_M12/B X2_M12/G VDD X2_M12/G sky130_fd_pr__pfet_01v8_lvt_ZPPFMQ
XX2_M13 X2_M13/B X2_M16/B X2_M12/G VDD X2_M12/G X2_M16/B X2_M12/G VDD X2_M12/G X2_M16/B
+ X2_M12/G VDD X2_M12/G X2_M16/B X2_M12/G X2_M13/S7 X2_M12/G sky130_fd_pr__pfet_01v8_lvt_D7EHUM
XX2_M14 X2_M14/B X2_M14/D0 X2_M12/G X2_M14/S1 X2_M12/G X2_M14/D2 X2_M12/G X2_M14/S3
+ X2_M12/G X2_M14/D4 X2_M12/G X2_M14/S5 X2_M12/G sky130_fd_pr__pfet_01v8_lvt_Z7GDFQ
XX2_M15 X2_M16/B X2_M9/D R4/R1 X2_M16/B R4/R1 X2_M9/D R4/R1 X2_M16/B R4/R1 X2_M9/D
+ sky130_fd_pr__pfet_01v8_lvt_EH7T5T
XX2_M16 X2_M16/B X2_M9/G X2_M16/G3 X2_M16/B X2_M16/G3 X2_M9/G X2_M16/G3 X2_M16/B X2_M16/G3
+ X2_M9/G sky130_fd_pr__pfet_01v8_lvt_EH7T5T
XQ2_0 Q2_E VSUBS VSUBS sky130_fd_pr__rf_pnp_05v5_W3p40L3p40 m=1
.ends
