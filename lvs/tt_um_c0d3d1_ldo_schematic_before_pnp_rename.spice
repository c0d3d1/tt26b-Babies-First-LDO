* LVS-cleaned schematic netlist generated by make_lvs_schematic.py
* Source: lvs/tt_um_c0d3d1_ldo_schematic.spice

.subckt tt_um_c0d3d1_ldo clk ena rst_n ua[0] ua[1] ua[2] ua[3] ua[4] ua[5] ua[6] ua[7]
XQ2[7] GND GND net5 sky130_fd_pr__pnp_05v5_W3p40L3p40 m=1 mult=1
XQ2[6] GND GND net5 sky130_fd_pr__pnp_05v5_W3p40L3p40 m=1 mult=1
XQ2[5] GND GND net5 sky130_fd_pr__pnp_05v5_W3p40L3p40 m=1 mult=1
XQ2[4] GND GND net5 sky130_fd_pr__pnp_05v5_W3p40L3p40 m=1 mult=1
XQ2[3] GND GND net5 sky130_fd_pr__pnp_05v5_W3p40L3p40 m=1 mult=1
XQ2[2] GND GND net5 sky130_fd_pr__pnp_05v5_W3p40L3p40 m=1 mult=1
XQ2[1] GND GND net5 sky130_fd_pr__pnp_05v5_W3p40L3p40 m=1 mult=1
XQ2[0] GND GND net5 sky130_fd_pr__pnp_05v5_W3p40L3p40 m=1 mult=1
XQ1 GND GND net1 sky130_fd_pr__pnp_05v5_W3p40L3p40 m=1 mult=1
x6 net1 net2 net4 Vdd GND DEV_OPAMP
XM13 Vref net4 Vdd Vdd sky130_fd_pr__pfet_01v8_lvt L=0.36 W=30 nf=4 ad='int((nf+1)/2) * W/nf * 0.29' as='int((nf+2)/2) * W/nf * 0.29'
+ pd='2*int((nf+1)/2) * (W/nf + 0.29)' ps='2*int((nf+2)/2) * (W/nf + 0.29)' nrd='0.29 / W' nrs='0.29 / W' sa=0 sb=0 sd=0 mult=1 m=1
XM1 net3 net4 Vdd Vdd sky130_fd_pr__pfet_01v8_lvt L=0.36 W=30 nf=4 ad='int((nf+1)/2) * W/nf * 0.29' as='int((nf+2)/2) * W/nf * 0.29'
+ pd='2*int((nf+1)/2) * (W/nf + 0.29)' ps='2*int((nf+2)/2) * (W/nf + 0.29)' nrd='0.29 / W' nrs='0.29 / W' sa=0 sb=0 sd=0 mult=1 m=1
x2 Vref net6 net7 Vdd GND DEV_OPAMP
XM2 ua[0] net7 Vdd Vdd sky130_fd_pr__pfet_01v8 L=0.18 W=88 nf=12 ad=12.76 as=14.8866666666667 pd=91.48 ps=106.726666666667
+ nrd=0.00329545454545455 nrs=0.00329545454545455 sa=0 sb=0 sd=0 mult=1 m=1
XM3 net1 net1 Vdd Vdd sky130_fd_pr__pfet_01v8_hvt L=0.36 W=1.8 nf=1 ad=0.522 as=0.522 pd=4.18 ps=4.18 nrd=0.161111111111111
+ nrs=0.161111111111111 sa=0 sb=0 sd=0 mult=1 m=1
XR8 net1 net3 GND sky130_fd_pr__res_high_po_0p69 L=15.9 mult=1 m=1
XR1 net2 Vref GND sky130_fd_pr__res_high_po_0p69 L=14.5 mult=1 m=1
XR2 net5 net2 GND sky130_fd_pr__res_high_po_0p69 L=0.9 mult=1 m=1
XR3 net6 ua[0] GND sky130_fd_pr__res_high_po_0p69 L=7.4 mult=1 m=1
XR4 GND net6 GND sky130_fd_pr__res_high_po_0p69 L=48 mult=1 m=1
.ends tt_um_c0d3d1_ldo

* expanding   symbol:  DEV_OPAMP.sym # of pins=5
** sym_path: /opt/eda/share/xschem/xschem_library/devices/DEV_OPAMP.sym
** sch_path: /opt/eda/share/xschem/xschem_library/devices/DEV_OPAMP.sch
.subckt DEV_OPAMP MINUS PLUS DIFFOUT VCC GND
*.ipin VCC
*.opin DIFFOUT
*.ipin GND
*.ipin MINUS
*.ipin PLUS
XM9 vgn2 vgn1 GND GND sky130_fd_pr__nfet_01v8 L=0.36 W=6 nf=1 ad='int((nf+1)/2) * W/nf * 0.29' as='int((nf+2)/2) * W/nf * 0.29' pd='2*int((nf+1)/2) * (W/nf + 0.29)'
+ ps='2*int((nf+2)/2) * (W/nf + 0.29)' nrd='0.29 / W' nrs='0.29 / W' sa=0 sb=0 sd=0 mult=1 m=1
XM10 vgn1 vgn1 GND GND sky130_fd_pr__nfet_01v8 L=0.36 W=6 nf=1 ad='int((nf+1)/2) * W/nf * 0.29' as='int((nf+2)/2) * W/nf * 0.29' pd='2*int((nf+1)/2) * (W/nf + 0.29)'
+ ps='2*int((nf+2)/2) * (W/nf + 0.29)' nrd='0.29 / W' nrs='0.29 / W' sa=0 sb=0 sd=0 mult=1 m=1
XM11 DIFFOUT vgn2 GND GND sky130_fd_pr__nfet_01v8 L=0.36 W=18 nf=2 ad='int((nf+1)/2) * W/nf * 0.29' as='int((nf+2)/2) * W/nf * 0.29'
+ pd='2*int((nf+1)/2) * (W/nf + 0.29)' ps='2*int((nf+2)/2) * (W/nf + 0.29)' nrd='0.29 / W' nrs='0.29 / W' sa=0 sb=0 sd=0 mult=1 m=1
XM12 ua[1] ua[1] VCC VCC sky130_fd_pr__pfet_01v8_lvt L=0.72 W=3 nf=4 ad='int((nf+1)/2) * W/nf * 0.29' as='int((nf+2)/2) * W/nf * 0.29'
+ pd='2*int((nf+1)/2) * (W/nf + 0.29)' ps='2*int((nf+2)/2) * (W/nf + 0.29)' nrd='0.29 / W' nrs='0.29 / W' sa=0 sb=0 sd=0 mult=1 m=1
XM13 net1 ua[1] VCC VCC sky130_fd_pr__pfet_01v8_lvt L=0.72 W=30 nf=4 ad='int((nf+1)/2) * W/nf * 0.29' as='int((nf+2)/2) * W/nf * 0.29'
+ pd='2*int((nf+1)/2) * (W/nf + 0.29)' ps='2*int((nf+2)/2) * (W/nf + 0.29)' nrd='0.29 / W' nrs='0.29 / W' sa=0 sb=0 sd=0 mult=1 m=1
XM14 DIFFOUT ua[1] VCC VCC sky130_fd_pr__pfet_01v8_lvt L=0.72 W=45 nf=4 ad='int((nf+1)/2) * W/nf * 0.29' as='int((nf+2)/2) * W/nf * 0.29'
+ pd='2*int((nf+1)/2) * (W/nf + 0.29)' ps='2*int((nf+2)/2) * (W/nf + 0.29)' nrd='0.29 / W' nrs='0.29 / W' sa=0 sb=0 sd=0 mult=1 m=1
XM15 vgn2 PLUS net1 net1 sky130_fd_pr__pfet_01v8_lvt L=0.36 W=36 nf=4 ad='int((nf+1)/2) * W/nf * 0.29' as='int((nf+2)/2) * W/nf * 0.29'
+ pd='2*int((nf+1)/2) * (W/nf + 0.29)' ps='2*int((nf+2)/2) * (W/nf + 0.29)' nrd='0.29 / W' nrs='0.29 / W' sa=0 sb=0 sd=0 mult=1 m=1
XM16 vgn1 MINUS net1 net1 sky130_fd_pr__pfet_01v8_lvt L=0.36 W=36 nf=4 ad='int((nf+1)/2) * W/nf * 0.29' as='int((nf+2)/2) * W/nf * 0.29'
+ pd='2*int((nf+1)/2) * (W/nf + 0.29)' ps='2*int((nf+2)/2) * (W/nf + 0.29)' nrd='0.29 / W' nrs='0.29 / W' sa=0 sb=0 sd=0 mult=1 m=1
XC2 net2 vgn2 sky130_fd_pr__cap_mim_m3_1 W=90 L=22.5 MF=1 m=1
XR2 DIFFOUT net2 GND sky130_fd_pr__res_high_po_5p73 L=5.73 mult=1 m=1
XC1 DIFFOUT GND sky130_fd_pr__cap_mim_m3_1 W=15 L=18 MF=1 m=1
.ends

.GLOBAL GND
.end
